# Ansys Electronics Desktop project, version 2025.2
materials:
  vacuum: permittivity=1
  copper: permeability=0.999991 conductivity=58000000

design Maxwell3DDesign1 (Maxwell 3D, AC Magnetic, model units mm)
geometry:
  Sweep1, Sweep1_1 [copper] = imported_body(C:\Users\Andrew A. Katz\Documents\ESE6710\Final Project\Coils.STEP)
  group RX = Sweep1
  group TX = Sweep1_1
boundaries and excitations:
  CoilTerminal1: Coil Terminal Faces=Sweep1_1.face(at (19.05, 0, 26.9875)) Conductor_number=1 Winding=TX Point_out_of_terminal=false
  CoilTerminal2: Coil Terminal Faces=Sweep1_1.face(at (49.5296, 0.0466835, 26.9875)) Conductor_number=1 Winding=TX Point_out_of_terminal=true
  CoilTerminal3: Coil Terminal Faces=Sweep1.face(at (19.05, 0, 0)) Conductor_number=1 Winding=RX Point_out_of_terminal=false
  CoilTerminal4: Coil Terminal Faces=Sweep1.face(at (49.5296, 0.0466835, 0)) Conductor_number=1 Winding=RX Point_out_of_terminal=true
  TX: Winding Group Type=Current IsSolid=true Current=1A ParallelBranchesNum=1 Phase=0deg
  RX: Winding Group Type=External IsSolid=true Current=0mA ParallelBranchesNum=1 Phase=0deg
  external circuit: "* Design: Coils_ckt"
mesh:
  SkinDepth1: SkinDepthBased Objects=Sweep1_1 NumMaxElem=100 SkinDepth=0.01mm SurfTriMaxLength=30mm NumLayers=1
  SkinDepth2: SkinDepthBased Objects=Sweep1 NumMaxElem=100 SkinDepth=0.01mm SurfTriMaxLength=30mm NumLayers=1
  initial mesh: GlobalSurfApproximation{CurvedSurfaceApproxChoice=UseSlider SliderMeshSettings=1} GlobalCurvilinear{Apply}
setups:
  Setup1: AC Magnetic MaximumPasses=10 MinimumPasses=2 MinimumConvergedPasses=1 PercentRefinement=30 PercentError=10 NonLinearResidual=0.0001 Frequency=6.78MHz SweepRanges{point 6.78MHz} SaveAllFields LossAdaptiveCtrl=0.5
output variables:
  RXVoltage = InducedVoltage(RX)
  TXCurrent = InputCurrent(TX)
  RXCurrent = Current(RX)
field plots:
  Vector_B1: B in Sweep1 on Setup1 : LastAdaptive at Freq=6.78MHz Phase=0deg
reports:
  Winding Table1: InducedVoltage(RX) vs Freq on Setup1 : LastAdaptive
  Winding Table2: Current(RX) vs Freq on Setup1 : LastAdaptive
  Winding Table3: FluxLinkage(RX) vs Freq on Setup1 : LastAdaptive
  Winding Table4: InputCurrent(TX), InducedVoltage(TX) vs Freq on Setup1 : LastAdaptive

design Coils_ckt (Maxwell Circuit)
components:
  Winding_2 = Winding(Name=RX)
  Res_7 = Res()
  Voltmeter_8 = Voltmeter()
nets:
  0: Voltmeter_8.1, Winding_2.1, Res_7.1
  net_1: Voltmeter_8.0, Winding_2.0, Res_7.0
